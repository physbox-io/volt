* Test logic gates
V1 in1 0 DC 5
V2 in2 0 DC 0
B_and out_and 0 V = V(in1) > 2.5 ? (V(in2) > 2.5 ? 5 : 0) : 0
B_or out_or 0 V = V(in1) > 2.5 ? 5 : (V(in2) > 2.5 ? 5 : 0)
B_not out_not 0 V = V(in1) > 2.5 ? 0 : 5
B_xor out_xor 0 V = V(in1) > 2.5 ? (V(in2) > 2.5 ? 0 : 5) : (V(in2) > 2.5 ? 5 : 0)
.op
.print op V(out_and) V(out_or) V(out_not) V(out_xor)
.end
